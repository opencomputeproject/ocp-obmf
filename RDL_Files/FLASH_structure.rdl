`ifndef FLASH_STRUCTURE_RDL
`define FLASH_STRUCTURE_RDL

regfile FLASH_structure {
    name = "OBMF_FLASH_STRUCTURE";
    desc = "FLASH Registers";
    structure_version   = "1.0";
    
    channel_type_guid   = 0x1234_2316_8094_F001_8090_0124_5678_90AB; //FLASH
    read_supported      = true;                 // Indicates if OBMF-ICP Secondary supports Read transactions
    write_supported     = false;                // Indicates if OBMF-ICP Secondary supports Write transactions

    FLASH_SPACE_REG FLASH_SPACE[1] @ 0x0000;
    
    reg {
        name = "ERASE_START_ADDRESS";
        desc = "Erase cycle start address (note: devices typically require erase to start on block boundary).";
        regwidth = 32;

        field {
            desc = "Erase start address";
            sw = rw;
        }ERASE_START_ADDRESS [31:0]= 0x00;
    }ERASE_START_ADDRESS @ 0x1000; // offset 0x1000

    reg {
        name = "ERASE_SIZE";
        desc = "Erase size in bytes (note: devices usually only support specific erase sizes).";
        regwidth = 32;

        field {
            desc = "Erase size in bytes";
            sw = rw;
        } ERASE_SIZE [31:0]= 0x00;
    }ERASE_SIZE @ 0x1004; // offset 0x1004
};

`endif